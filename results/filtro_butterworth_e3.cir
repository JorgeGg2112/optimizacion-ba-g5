* Filtro Butterworth 4to Orden Sallen-Key (fc = 1 kHz) - Grupo 5
Vin in 0 AC 1

* Etapa 1 (Q1* = 0.5412)
R1_1 in n1 1000
R2_1 n1 n2 2700
C1_1 n1 out1 1.200000e-07
C2_1 n2 0 8.200000e-08
E1 out1 0 n2 out1 1e6

* Etapa 2 (Q2* = 1.3066)
R1_2 out1 n3 2000
R2_2 n3 n4 1800
C1_2 n3 out 2.700000e-07
C2_2 n4 0 3.900000e-08
E2 out 0 n4 out 1e6

.ac dec 200 10 100k
.end
